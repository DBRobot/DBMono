* SEQ 24V Fault Current Analysis
* DBCAN_V1.0 - Sustained overvoltage on connector pin
*
* Scenario: 12V or 24V accidentally applied to SEQ connector pin.
* MCU GPIO is in open-drain high-Z mode.
*
* Updated topology:
*   +5V --- R_pullup (10k) --- connector pin --- D_esd (PESD5V0L1UL) --- GND
*                                    |
*                               R_series (1k)
*                                    |
*                               MCU GPIO (FT pin, open-drain, high-Z)
*
* PESD5V0L1UL (unidirectional, anode=GND, cathode=conn_pin):
*   - Vbr = 6.8V, Vc = 9V @ 1A, Vc = 12V @ 3.5A
*   - Dynamic resistance from clamp data:
*     9V @ 1A -> Rs_eff = (9-6.8)/1 = 2.2 ohm
*     12V @ 3.5A -> Rs_eff = (12-6.8)/3.5 = 1.49 ohm
*   - Use Rs=0.5 for SPICE (conservative, better at high current)
*   - SOD-882 thermal: ~250mW sustained
*
* KEY INSIGHT: The PESD5V0L1UL is rated for ESD transients only.
* Under sustained 24V fault with low source impedance, the diode
* will carry amps of current and be destroyed thermally.
* The 1k series R + FT pin protection is the secondary defense.
*
* STM32 FT pin: NO upper clamp to VDD. Abs max = 7.3V.
* Internal ESD structure conducts above ~7.3V.
*
* =====================================================================

* +5V supply
V5 vdd 0 DC 5.0

* 3.3V MCU supply
V33 vdd_mcu 0 DC 3.3

* Pull-up resistor
R_pullup vdd conn_pin 10k

* ESD protection diode (PESD5V0L1UL) - unidirectional
* Anode=GND, Cathode=conn_pin
* Rs adjusted lower to better match high-current clamp behavior
.model PESD5V0L1UL D (
+   Is=1p N=1.05 Rs=0.5
+   Bv=6.8 Ibv=1m
+   Cjo=25p Vj=0.7 M=0.5 )

D_esd 0 esd_a PESD5V0L1UL
V_am_esd esd_a conn_pin DC 0

* Series resistor with ammeter
R_series conn_pin rseries_out 1k
V_am_rs rseries_out mcu_pin DC 0

* =====================================================================
* STM32G0B1 FT Pin Model
* NO upper clamp to VDD. Internal ESD protection at ~7.3V.
* =====================================================================
.model MCU_FT_PROT D (
+   Is=1p N=1.1 Rs=50
+   Bv=7.3 Ibv=100u
+   Cjo=3p Vj=0.7 M=0.5 )

.model MCU_CLAMP_DN D (Is=1n N=1.7 Rs=50)

D_mcu_prot 0 prot_a MCU_FT_PROT
V_am_prot prot_a mcu_pin DC 0

D_mcu_dn 0 mcu_pin MCU_CLAMP_DN

* MCU pin capacitance
C_gpio mcu_pin 0 5p

* Trace capacitance
C_trace conn_pin 0 10p

* =====================================================================
* Fault scenarios: sweep 5V, 12V, 24V
* Source impedance = 1 ohm (worst case, direct power rail)
* =====================================================================
R_fault fault_src conn_pin 1
V_fault fault_src 0 PWL(
+ 0      0
+ 5u     0
+ 5.1u   5
+ 20u    5
+ 20.1u  12
+ 50u    12
+ 50.1u  24
+ 80u    24
+ 80.1u  0
+ 100u   0 )

* =====================================================================
* Simulation Control
* =====================================================================
.OPTIONS RELTOL=0.003 VNTOL=1m ABSTOL=1u CHGTOL=1p GMIN=1E-9
+ ITL1=1000 ITL2=1000 ITL4=500 METHOD=GEAR TRTOL=7

.tran 100n 100u UIC

.control
  set ngbehavior=psa
  set filetype = ascii
  set wr_singlescale
  set wr_vecnames

  run

  echo ""
  echo "=== SEQ 24V Fault Current Analysis (1 ohm source) ==="
  echo ""

  * Normal 5V operation (8-18us)
  meas tran V_conn_5v AVG V(conn_pin) from=8u to=18u
  meas tran V_mcu_5v AVG V(mcu_pin) from=8u to=18u

  * 12V fault (25-45us)
  meas tran V_conn_12v AVG V(conn_pin) from=25u to=45u
  meas tran V_mcu_12v AVG V(mcu_pin) from=25u to=45u
  meas tran I_series_12v AVG v_am_rs#branch from=25u to=45u
  meas tran I_esd_12v AVG v_am_esd#branch from=25u to=45u
  meas tran I_prot_12v AVG v_am_prot#branch from=25u to=45u

  * 24V fault (55-75us)
  meas tran V_conn_24v AVG V(conn_pin) from=55u to=75u
  meas tran V_mcu_24v AVG V(mcu_pin) from=55u to=75u
  meas tran I_series_24v AVG v_am_rs#branch from=55u to=75u
  meas tran I_esd_24v AVG v_am_esd#branch from=55u to=75u
  meas tran I_prot_24v AVG v_am_prot#branch from=55u to=75u

  * Peak values during 24V fault
  meas tran V_conn_peak MAX V(conn_pin) from=50u to=80u
  meas tran V_mcu_peak MAX V(mcu_pin) from=50u to=80u

  * Power in ESD diode at 24V (thermal concern)
  * P = V_clamp * I_esd

  echo ""
  echo "=== Limits ==="
  echo "STM32G0B1 FT pin abs max: VDD+4V = 7.3V"
  echo "STM32G0B1 abs max injection current: +/-5mA per pin"
  echo "PESD5V0L1UL max sustained: ~250mW (SOD-882)"
  echo ""

  wrdata seq_fault_24v.csv V(conn_pin) V(mcu_pin) v_am_rs#branch v_am_esd#branch v_am_prot#branch

  quit
.endc

.end
